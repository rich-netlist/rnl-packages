// Five-transistor OTA in SkyWater SKY130 (sky130_fd_pr), Spectre dialect (no X prefix)
// include "sky130_fd_pr_stub.scs"
M1 (x inp tail 0) sky130_fd_pr__nfet_01v8 w=4u l=0.15u
M2 (out inn tail 0) sky130_fd_pr__nfet_01v8 w=4u l=0.15u
M3 (x x vdd vdd) sky130_fd_pr__pfet_01v8 w=8u l=0.15u
M4 (out x vdd vdd) sky130_fd_pr__pfet_01v8 w=8u l=0.15u
M5 (tail bias 0 0) sky130_fd_pr__nfet_01v8 w=8u l=0.5u
M6 (bias bias 0 0) sky130_fd_pr__nfet_01v8 w=8u l=0.5u
Ib (vdd bias) isource dc=20u
CL (out 0) sky130_fd_pr__cap_mim_m3_1 w=10u l=10u
Vdd (vdd 0) vsource dc=1.8
// @RNL(type="header") {
//   @VERSION("0.4");
//   @USE-PACKAGE(name="rnl-std-all", version="0.4");
//   @USE-PACKAGE(name="pdk-sky130", version="0.2")
// }
// @RNL {
//   &vdd @ADD-TO $SUPPLY_NET_SET;
//   # @SELECT-INSTANCE(model="sky130_fd_pr__*fet*", recursive=true) => @TEXT("W/L=${w}/${l}", key="model");
//   #CL @TEXT("${w}\times{}${l}", key="value");
//
//   %dp = #M1(left) #M2(right) #M5(tail) @AS $DIFFERENTIAL_PAIR_N;
//   %cm = {#M3}(ref) {#M4}(out) @AS $CURRENT_MIRROR_P;
//
//   %jd = (-6, 4); %jg = (-2, 8); %jo = (6, 4); %jc = (16, 4); %jt = (0, -5);
//   %jb = (-22, -5); %j6 = (-14, -8);
//   &x @WIRE {#M3:d %jd #M1:d};
//   &x @WIRE {#M3:g %jg #M4:g};
//   &x @WIRE(mode="horizontal-vertical") {%jd %jg};
//   &out @WIRE {#M4:d %jo #M2:d};
//   &tail @WIRE(mode="vertical-horizontal") {#M1:s %jt};
//   &tail @WIRE(mode="vertical-horizontal") {#M2:s %jt};
//   &tail @WIRE {%jt #M5:d};
//   &bias @WIRE {#Ib:n %jb #M6:d};
//   &bias @WIRE {#M6:g %j6 #M5:g};
//   &bias @WIRE(mode="vertical-horizontal") {%j6 %jb};
//   $JUNCTION @ATTACH %jd => @PLACE(-6, 4);
//   $JUNCTION @ATTACH %jg => @PLACE(-2, 8);
//   $JUNCTION @ATTACH %jo => @PLACE(6, 4);
//   $JUNCTION @ATTACH %jc => @PLACE(16, 4);
//   $JUNCTION @ATTACH %jt => @PLACE(0, -5);
//   $JUNCTION @ATTACH %jb => @PLACE(-22, -5);
//   $JUNCTION @ATTACH %j6 => @PLACE(-14, -8);
//
//   %pi = $NET_LABEL @ATTACH &inp;
//   $NET_LABEL @ATTACH &inn => @ORIENT("MY") => %pn;
//   $NET_LABEL @ATTACH &out => @ORIENT("MY") => %po;
//   &inp @WIRE {%pi::pin #M1:g};
//   &inn @WIRE {%pn::pin #M2:g};
//   &out @WIRE {%jo %jc %po::pin};
//   &out @WIRE {%jc #CL:c0}
// }
// @RNL(type="generated", priority="high") {
//   #M1 @PLACE(-6, 0); #M2 @PLACE(6, 0) => @ORIENT("MY");
//   #M3 @PLACE(-6, 8) => @ORIENT("MY"); #M4 @PLACE(6, 8);
//   #M5 @PLACE(0, -8); #M6 @PLACE(-22, -8) => @ORIENT("MY"); #Ib @PLACE(-22, 0);
//   #CL @PLACE(16, 1); #Vdd @PLACE(28, 4);
//   %pi @PLACE(-11, 0); %pn @PLACE(11, 0); %po @PLACE(21, 4);
//   %gs_M1_b = $GROUND_STUB @ATTACH(gap=2) #M1:b; %gs_M1_b::g @PLACE(-4, -2);
//   %gs_M2_b = $GROUND_STUB @ATTACH(gap=2) #M2:b; %gs_M2_b::g @PLACE(4, -2);
//   %gs_M5_s = $GROUND_STUB @ATTACH(gap=2) #M5:s; %gs_M5_s::g @PLACE(0, -12);
//   %gs_M5_b = $GROUND_STUB @ATTACH(gap=2) #M5:b; %gs_M5_b::g @PLACE(1, -11);
//   %gs_M6_s = $GROUND_STUB @ATTACH(gap=2) #M6:s; %gs_M6_s::g @PLACE(-22, -12);
//   %gs_M6_b = $GROUND_STUB @ATTACH(gap=2) #M6:b; %gs_M6_b::g @PLACE(-23, -11);
//   %gs_CL_c1 = $GROUND_STUB @ATTACH(gap=2) #CL:c1; %gs_CL_c1::g @PLACE(16, -3);
//   %gs_Vdd_n = $GROUND_STUB @ATTACH(gap=2) #Vdd:n; %gs_Vdd_n::g @PLACE(28, -1);
//   %ss_M3_s = $SUPPLY_STUB @ATTACH(gap=2) #M3:s; %ss_M3_s::s @PLACE(-6, 12);
//   %ss_M3_b = $SUPPLY_STUB @ATTACH(gap=2) #M3:b; %ss_M3_b::s @PLACE(-7, 11);
//   %ss_M4_s = $SUPPLY_STUB @ATTACH(gap=2) #M4:s; %ss_M4_s::s @PLACE(6, 12);
//   %ss_M4_b = $SUPPLY_STUB @ATTACH(gap=2) #M4:b; %ss_M4_b::s @PLACE(7, 11);
//   %ss_Ib_p = $SUPPLY_STUB @ATTACH(gap=2) #Ib:p; %ss_Ib_p::s @PLACE(-22, 5);
//   %ss_Vdd_p = $SUPPLY_STUB @ATTACH(gap=2) #Vdd:p; %ss_Vdd_p::s @PLACE(28, 9)
// }

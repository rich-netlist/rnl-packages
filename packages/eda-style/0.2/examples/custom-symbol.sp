* Independent EDA geometry and style, including a user-defined symbol
* @RNL(type="header") {
*   @VERSION("0.4");
*   @USE-PACKAGE(name="rnl-std-all", version="0.4");
*   @USE-PACKAGE(name="eda-symbol", version="0.2");
*   @USE-PACKAGE(name="eda-style", version="0.2")
* }
.subckt custom p n
.ends custom
R1 a b 1k
X1 a b custom
* @RNL {
*   $CUSTOM = @DEFINE-SYMBOL(box=[-2, -1, 2, 1]) {
*     @RECTANGLE {(-1, -1) (1, 1)};
*     @LINE {(-2, 0) (-1, 0)};
*     @LINE {(1, 0) (2, 0)};
*     %p = (-2, 0) @PIN(terminal="p", direction="left");
*     %n = (2, 0) @PIN(terminal="n", direction="right");
*     (0, 0) @TEXT("custom", halign="middle", valign="middle", size=0.5)
*   };
*   #R1 @PLACE(-8, 0);
*   #X1 @SET-SYMBOL $CUSTOM;
*   #X1 @PLACE(8, 0);
*   &a @WIRE {#R1:1 (-8, 5) (4, 5) (4, 0) #X1:1};
*   %ground = $GROUND @ATTACH &a => @PLACE(-8, -10);
*   %supply = $SUPPLY @ATTACH &b => @PLACE(0, -10);
*   %unused = $NO_CONNECT @ATTACH #X1:2 => @PLACE(10, 0)
* }
.end
